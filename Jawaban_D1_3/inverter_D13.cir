D1.3 - Inverter CMOS pedagogis, VDD 5 V
VDD dd 0 5
VIN in 0 0
MN out in 0 0 N1 W=10u L=1u
MP out in dd dd P1 W=20u L=1u
.model N1 NMOS(level=1 VTO=0.8 KP=100u LAMBDA=0.04)
.model P1 PMOS(level=1 VTO=-0.8 KP=50u LAMBDA=0.04)
CL out 0 20p
.temp 27
.options reltol=1e-7 vntol=1e-9
.control
dc VIN 0 5 0.001
meas dc out_minus FIND v(out) AT=2.48
meas dc out_center FIND v(out) AT=2.50
meas dc out_plus FIND v(out) AT=2.52
meas dc i_center FIND i(VDD) AT=2.50
* Di jendela ngspice, ketik: plot v(out) v(in)
.endc
.end
