D2.3 - quick_restart, 10 uF
VDD dd 0 PWL(0 5 10m 5 10.01m 0 10.21m 0 10.22m 5)
Cc dd x 10u
Rs x rst 1k
Rext rst 0 10k
Rint rst 0 100k
Dclamp 0 rst DM
.model DM D(IS=1n N=1)
.temp 27
.control
set numdgt=12
set wr_singlescale
tran 2u 380m
wrdata wave.dat v(dd) v(rst)
.endc
.end
