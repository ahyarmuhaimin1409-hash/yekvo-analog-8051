Filter RC - T03-B
Vin in 0 AC 1
R1 in out 1k
C1 out 0 159n
* Tanpa beban tambahan
.control
ac lin 3 900 1100
let gain = mag(v(out)/v(in))
meas ac gain_1khz FIND gain AT=1000
quit
.endc
.end
