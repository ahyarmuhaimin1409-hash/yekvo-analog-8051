* YEKVO D1.3 Fault Test - Input Dekat Switching Threshold Vm=2.5V
VDD vdd 0 DC 5
* Sinyal DC 2.5V + gangguan noise sinus 0.3V (frekuensi 10 MHz)
VIN in 0 SIN(2.5 0.3 10Meg)

MP out in vdd vdd PM W=20u L=1u
MN out in 0 0 NM W=10u L=1u
CL out 0 20p

.model NM NMOS (LEVEL=1 VTO=0.8 KP=100u LAMBDA=0.02)
.model PM PMOS (LEVEL=1 VTO=-0.8 KP=50u LAMBDA=0.02)

.control
tran 0.5n 300n
let idd = -i(VDD)
wrdata results/inverter_noise_fault.csv v(in) v(out) idd
quit
.endc
.end
