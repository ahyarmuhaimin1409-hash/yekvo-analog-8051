* YEKVO CMOS Inverter - Transient (Teaching Model Only)
VDD vdd 0 DC 5
VIN in 0 PULSE(0 5 0n 2n 2n 100n 200n)

MP out in vdd vdd PM W=20u L=1u
MN out in 0 0 NM W=10u L=1u
CL out 0 20p

.model NM NMOS (LEVEL=1 VTO=0.8 KP=100u LAMBDA=0.02)
.model PM PMOS (LEVEL=1 VTO=-0.8 KP=50u LAMBDA=0.02)

.control
tran 0.5n 600n
let idd = -i(VDD)
wrdata results/inverter_transient.csv v(in) v(out) idd
quit
.endc
.end
