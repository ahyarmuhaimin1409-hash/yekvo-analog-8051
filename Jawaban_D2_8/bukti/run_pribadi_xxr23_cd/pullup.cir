Pengisian RC pada pin GPIO yang dilepas - pullup
.param RP=10k CL=100p
Vcc supply 0 5
Rpull supply pin {RP}
Cload pin 0 {CL} IC=0
.tran 1n 5u UIC
.control
run
meas tran t3 WHEN v(pin)=3 RISE=1
wrdata pullup.dat v(pin)
quit 0
.endc
.end
